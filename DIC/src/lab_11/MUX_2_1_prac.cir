* CMOS Inverter with Functions

.include cmos_65nm.txt

.param VDD = 2
*.param FREQ = 0.1Meg
.param PERIOD = 40
.param DELAY_COFF = 0

*pulse(Vlow Vhigh delay rise fall on_time period)
*Vin in 0 PULSE(0 {VDD} 0 {PERIOD * 0.01} {PERIOD * 0.01} {PERIOD * 0.6} {PERIOD})

*Vin in 0 {VDD}

*M<name> <drain> <gate> <source> <bulk> <model_name> [L=<length>] [W=<width>]

Vdd vdd 0 {VDD}

M1 in_1 S out vdd pmos W = 50u L = 65n
M2 out S1 in_1 0 nmos W = 32u L = 65n
M3 in_2 S1 out vdd pmos W = 50u L = 65n
M4 out S in_2 0 nmos W = 32u L = 65n

*Inverter
M5 S1 S vdd vdd pmos W = 50u L = 65n
M6 S1 S 0 0 nmos W = 32u L = 65n

* Load capacitor
CL out 0 10f

V_s S 0 PULSE(0 {VDD} {PERIOD * (0.5 - DELAY_COFF)} {PERIOD * DELAY_COFF} {PERIOD * DELAY_COFF} {PERIOD * (0.5 - DELAY_COFF)} {PERIOD})
Vin1 in_1 0 PULSE(0 {VDD} {PERIOD * (0.5 - DELAY_COFF)* 0.5} {PERIOD * DELAY_COFF} {PERIOD * DELAY_COFF} {PERIOD * (0.5 - DELAY_COFF)* 0.5} {PERIOD * 0.5})
Vin2 in_2 0 PULSE(0 {VDD} {PERIOD * (0.5 - DELAY_COFF) * 0.5 *0.5} {PERIOD * DELAY_COFF} {PERIOD * DELAY_COFF} {PERIOD * (0.5 - DELAY_COFF) * 0.5 * 0.5} {PERIOD * 0.5 * 0.5})
*.dc vin 0 {VDD} {PERIOD * 100}
*.tran {PERIOD / 100} {PERIOD * 5}
.tran {PERIOD*0.001} {PERIOD*2}
.control
run

* Color the graph
set color0 = white
set color1 = black
set xbrushwidth = 3

set hcopydevtype = postscript
hardcopy test.ps v(S)+9 v(in_1)+6 v(in_2)+3 v(out)
plot v(S)+10 v(in_1)+6 v(in_2)+3 v(out)

.endc
.end
