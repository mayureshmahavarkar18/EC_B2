cmos_inverter[U24EC123]

.include cmos_65nm.txt

M1 d g 0 0 nmos W = 32u L = 65n
VDD vdd 0 1.2
Rl vdd d 1k
vin g 0 1.2
.dc vin 0 1.2 0.001
.control
run
plot v(d) v(g)
set hcopydevtype = postscript
set hcopydevtype = svg
set color0= white
hardcopy nmos_inverter_10k.ps v(d) v(g)
hardcopy nmos_inverter_10k.svg v(d) v(g)
print v(d) v(g) > /tmp/circuit_output.txt
.endc
.end
